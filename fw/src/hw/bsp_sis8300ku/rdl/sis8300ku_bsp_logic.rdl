`include "sis8300ku_bsp_logic.vh" //automatically created and added by fwk with conf variables such a C_VERSION ...

/* default values of defined variables */
`ifndef C_ID
`define C_ID 0x1FF00005
`endif
`ifndef C_VERSION
`define C_VERSION 0x00000000
`endif
`ifndef C_PRJ_ID
`define C_PRJ_ID 0x00000000
`endif
`ifndef C_PRJ_VERSION
`define C_PRJ_VERSION 0x00000000
`endif
`ifndef C_PRJ_TIMESTAMP
`define C_PRJ_TIMESTAMP 0x00000000
`endif
`ifndef C_PRJ_SHASUM
`define C_PRJ_SHASUM 0x00000000
`endif
`ifndef C_PCIE_IRQ_CNT
`define C_PCIE_IRQ_CNT 16
`endif

reg spi_reg {
  desc = "Generic 8 bit SPI register" ;
  default sw = rw;
  default hw = rw;
  field {} data[8] ;
} ;

addrmap spi_ad9268 {
  // Highest register 0x100 "digital feature control register"
  desc = "AD9268 ADC SPI registers memory map";
  spi_reg spi_regs[257];
};

addrmap spi_ad9510 {
  desc = "AD9510 clock divider SPI registers memory map";
  spi_reg spi_regs[91];
};


addrmap sis8300ku_bsp_logic {

  desyrdl_interface = "AXI4L";

  reg {
    desc = "BSP identification number";
    default sw = r;
    default hw = r;
    field {} data[32] = `C_ID;
  } ID;

  reg {
    desc = "Version of BSP";
    default sw = r;
    default hw = r;
    field {} changes  [8] =  `C_VERSION & 0x000000FF;
    field {} patch    [8] = (`C_VERSION & 0x0000FF00) >> 8;
    field {} minor    [8] = (`C_VERSION & 0x00FF0000) >> 16;
    field {} major    [8] = (`C_VERSION & 0xFF000000) >> 24;
  } VERSION;

  reg {
    desc = "Project identification number";
    default sw = r;
    default hw = r;
    field {} data[32] = `C_PRJ_ID;
  } PRJ_ID;

  reg {
    desc = "Project version number";
    default sw = r;
    default hw = r;
    field {} changes  [8] =  `C_PRJ_VERSION & 0x000000FF;
    field {} patch    [8] = (`C_PRJ_VERSION & 0x0000FF00) >> 8;
    field {} minor    [8] = (`C_PRJ_VERSION & 0x00FF0000) >> 16;
    field {} major    [8] = (`C_PRJ_VERSION & 0xFF000000) >> 24;
  } PRJ_VERSION;

  reg {
    desc = "Project repository checksum";
    default sw = r;
    default hw = r;
    field {} data[32]= `C_PRJ_SHASUM;
  } PRJ_SHASUM;

  reg {
    desc = "Project compilation UNIX timestamp";
    default sw = r;
    default hw = r;
    field {} data[32] = `C_PRJ_TIMESTAMP;
  } PRJ_TIMESTAMP;

  reg {
    desc = "Scratch register for test puposes";
    default sw = rw;
    default hw = r;
    field {} data[32];
  } SCRATCH ;

  reg  {
    desc = "Resets board and application. Active low (set to 1 for normal operation)." ;
    default sw = rw;
    default hw = r;
    field {} data[1] ;
  } RESET_N ;

  reg  {
    desc =
    "Set clock muxes, direct to muxes IO [br]
    [0] - MUX1A[br]
    [1] - MUX1B[br]
    [2] - MUX2A[br]
    [3] - MUX2B[br]
    [4] - MUXAB[br]
    [5] - MUXDAC
    " ;
    default sw = rw;
    default hw = r;
    field {} data[1:0] ;
  } CLK_MUX[6] ;

  reg {
    desc = "select clock source for application part (frequency of the generated clock depends on CON_EXT_FREQ)[br]
    0 - Application clock generated by 125 MHz onboard crystal[br]
    1 - Application clock generated by CLK05 signal (output of AD9510 PLL)[br]
    (If there is a clock error this register will not effect the clock source for application part. (It will be automatically switched to on board crystal)" ;
    default sw = rw;
    default hw = r;
    field {} data[1] ;
  } CLK_SEL ;

  reg  {
    desc = "Drives the function pin of the both AD9510 PLLs on board.+ The functionality of this pin can be changed by configuration of the PLL." ;
    default sw = rw;
    default hw = r;
    field {} data[1] ;
  } CLK_RST ;

  reg {
    desc = "Provides the frequency of clocks in Hz in reference to 125MHz crystal[br]
    [0] - Board clock[br]
    [1] - Output of the AD9510 (CLK05)[br]
    [2] - LLL Clock 1[br]
    [3] - LLL Clock 2[br]
    [4] - LLL Clock 3[br]
    [5] - DAC Clock[br]
    [6] - AXI4 Master to DDR S2M Clock[br]
    [7] - Application clock" ;
    default sw = r;
    default hw = w;
    field {} data[31:0] ;
  } CLK_FREQ[8] ;

  reg  {
    desc = "Shows if the external clock frequency(CLK05) is equal to C_APP_FREQ" ;
    default sw = r;
    default hw = w;
    field {} data[1] ;
  } CLK_ERR ;

  reg  {
    desc = "Select which AD9510 to configure.[br]
    Leaving it 0 will make both AD8510 to get the SPI configurations." ;
    default sw = rw;
    default hw = r;
    field {} data[2] ;
  } SPI_DIV_SEL ;

  reg {
    desc = "AD9510 PLL chip SPI port is busy" ;
    default sw = r;
    default hw = w;
    field {} data[1] ;
  } SPI_DIV_BUSY ;

  reg  {
    desc = "Enables all the ADCs" ;
    default sw = rw;
    default hw = r;
    field {} data[1] ;
  } ADC_ENA ;

  reg {
    desc = "Shows the current IDELAY Value that is active" ;
    default sw = r;
    default hw = rw;
    field {} data[9];
  } ADC_IDELAY_CNT[5];

  reg  {
    desc = "Revert the phase of the clock on ADC logic. Used to correct swapped channels." ;
    default sw = rw;
    default hw = r;
    default swmod;
    field {} data[5] ;
  } ADC_REVERT_CLK ;

  reg  {
    desc = "Choose which ADC to configure[br]
    Writing 0 will choose all ADCs for writing or ADC1 for reading[br]
    Writing 1 will choose ADC1[br]
    Writing 2 will choose ADC2[br]
    Writing 3 will choose ADC3[br]
    Writing 4 will choose ADC4[br]
    Writing 5 will choose ADC5[br]
    Writing 6 or 7 will choose none";
    default sw = rw;
    default hw = r;
    field {} data[3] ;
  } SPI_ADC_SEL ;

  reg  {
    desc = "Shows if there is any SPI communication with any ADCa" ;
    default sw = r;
    default hw = rw;
    field {} data[1] ;
  } SPI_ADC_BUSY ;

  reg  {
    desc = "register to enable DAC.[br]
    0 - disabled,[br]
    1 - enabled";
    default sw = rw;
    default hw = r;
    field {} data[1] ;
  } DAC_ENA ;

  reg  {
    desc = "Increment IDELAY value of the DAC.[br]
    Writing 1 will increment by 1 Writing 0 will decrement by 1" ;
    default sw = rw;
    default hw = r;
    default swmod;
    field {} data[1] ;
  } DAC_IDELAY_INC ;

  reg {
    desc = "Shows the current IDELAY value for the DAC" ;
    default sw = r;
    default hw = rw;
    field {} data[9] ;
  } DAC_IDELAY_CNT ;

  reg {
    desc="DDR4 Calibration Done signal from MIG";
    default sw = r;
    default hw = rw;
    field {} data[1] ;
  } DDR_CALIB_DONE ;

  reg  {
    desc = "Shows if a server/script has initialized the board or not. Used to understand if board is configured after recovery of PCIe link failure[br]
    0 - not initialized,[br]
    1 - initialized" ;
    default sw = rw;
    default hw = r;
    field {} data[1] ;
  } BOOT_STATUS;

  reg {
    desc="Enables the PCIe MSI Interrupts";
    default sw = rw;
    default hw = r;
    field {} data[1];
  } PCIE_IRQ_ENA[`C_PCIE_IRQ_CNT];

  reg {
    desc="Counts if Acknowledgement from xDMA is late by certain time period after application sends IRQ request";
    default sw = r;
    default hw = w;
    field {} data[32];
  } PCIE_IRQ_ACK_TIMEOUT[`C_PCIE_IRQ_CNT];

  fpga_config_manager FCM @0x10000;

  external spi_ad9510 AREA_SPI_DIV;
  AREA_SPI_DIV->desyrdl_interface = "AXI4L";
  external spi_ad9268 AREA_SPI_ADC;
  AREA_SPI_ADC->desyrdl_interface = "AXI4L";
  
};
